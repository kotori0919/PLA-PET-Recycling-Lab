* Auto-generated testbench for voltage divider: R25/R33
* Expected Vout = 3.3 * 0.997877 = 3.2930 V
* Model: ideal passives (exact, unloaded)

VIN BUF_HEATER_EXT_Z1 0 DC 3.3
R25 BUF_HEATER_EXT_Z1 OUT_HEATER_EXT_Z1 100
R33 OUT_HEATER_EXT_Z1 0 47k

.control
op
let vout_sim = v(OUT_HEATER_EXT_Z1)
let error_pct = abs(vout_sim - 3.2929941) / 3.2929941 * 100
echo "vout_sim=$&vout_sim error_pct=$&error_pct expected=3.2929941" > electronics/pcb/interface_board/analysis/spice_work/voltage-divider_R25_R33.out
quit
.endc

.end
