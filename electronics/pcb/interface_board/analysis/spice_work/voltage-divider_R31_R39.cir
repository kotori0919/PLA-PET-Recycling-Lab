* Auto-generated testbench for voltage divider: R31/R39
* Expected Vout = 3.3 * 0.997877 = 3.2930 V
* Model: ideal passives (exact, unloaded)

VIN BUF_CONTACTOR_REQUEST 0 DC 3.3
R31 BUF_CONTACTOR_REQUEST OUT_CONTACTOR_REQUEST 100
R39 OUT_CONTACTOR_REQUEST 0 47k

.control
op
let vout_sim = v(OUT_CONTACTOR_REQUEST)
let error_pct = abs(vout_sim - 3.2929941) / 3.2929941 * 100
echo "vout_sim=$&vout_sim error_pct=$&error_pct expected=3.2929941" > electronics/pcb/interface_board/analysis/spice_work/voltage-divider_R31_R39.out
quit
.endc

.end
