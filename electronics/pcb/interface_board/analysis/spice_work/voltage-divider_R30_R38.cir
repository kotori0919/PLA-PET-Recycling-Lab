* Auto-generated testbench for voltage divider: R30/R38
* Expected Vout = 3.3 * 0.997877 = 3.2930 V
* Model: ideal passives (exact, unloaded)

VIN BUF_DRYER_PET 0 DC 3.3
R30 BUF_DRYER_PET OUT_DRYER_PET 100
R38 OUT_DRYER_PET 0 47k

.control
op
let vout_sim = v(OUT_DRYER_PET)
let error_pct = abs(vout_sim - 3.2929941) / 3.2929941 * 100
echo "vout_sim=$&vout_sim error_pct=$&error_pct expected=3.2929941" > electronics/pcb/interface_board/analysis/spice_work/voltage-divider_R30_R38.out
quit
.endc

.end
